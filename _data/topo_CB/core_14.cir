*auto-generated subcircuit netlist (from TopoGen)
.SUBCKT CKTCASE ipos ineg out b0 b1 b2 b3 vdd gnd
*.PININFO ipos:I ineg:I out:O b0:B b1:B b2:B b3:B vdd:B gnd:B

Mn1 p1 ipos n_tail_2 gnd nmos W=w_Mn1 L=l_Mn1
Mn2 n_diff_1 ineg n_tail_2 gnd nmos W=w_Mn2 L=l_Mn2
Mp1 p1 n_diff_1 vdd vdd pmos W=w_Mp1 L=l_Mp1
Mp2 n_diff_1 n_diff_1 vdd vdd pmos W=w_Mp2 L=l_Mp2
Mtail1 n_tail_2 b0 gnd gnd nmos W=w_Mtail1 L=l_Mtail1
Mp3 n_series_3 p1 vdd vdd pmos W=w_Mp3 L=l_Mp3
Mp4 out b1 n_series_3 vdd pmos W=w_Mp4 L=l_Mp4
Mn3 out b2 gnd gnd nmos W=w_Mn3 L=l_Mn3
Mcb1 p1 b3 n_cb_4 gnd nmos W=w_Mcb1 L=l_Mcb1

Ccb1 out n_cb_4 c=c_Ccb1
CL out gnd c=c_CL
.ENDS CKTCASE
