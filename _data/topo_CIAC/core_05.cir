*auto-generated subcircuit netlist (from TopoGen)
.SUBCKT CKTCASE ipos ineg out b0 b1 b2 b3 vdd gnd
*.PININFO ipos:I ineg:I out:O b0:B b1:B b2:B b3:B vdd:B gnd:B

Mp1 p1 ipos n_tail_2 vdd pmos W=w_Mp1 L=l_Mp1
Mp2 n_diff_1 ineg n_tail_2 vdd pmos W=w_Mp2 L=l_Mp2
Mn1 p1 n_diff_1 gnd gnd nmos W=w_Mn1 L=l_Mn1
Mn2 n_diff_1 n_diff_1 gnd gnd nmos W=w_Mn2 L=l_Mn2
Mtail1 n_tail_2 b0 vdd vdd pmos W=w_Mtail1 L=l_Mtail1
Mp3 p2 p1 vdd vdd pmos W=w_Mp3 L=l_Mp3
Mref1 p2 p2 gnd gnd nmos W=w_Mref1 L=l_Mref1
Mmirror1 p3 p2 gnd gnd nmos W=w_Mmirror1 L=l_Mmirror1
Msupport1 p3 b1 vdd vdd pmos W=w_Msupport1 L=l_Msupport1
Mp4 out p3 vdd vdd pmos W=w_Mp4 L=l_Mp4
Mn3 out b2 gnd gnd nmos W=w_Mn3 L=l_Mn3
Mcb1 p1 b3 n_cb_3 gnd nmos W=w_Mcb1 L=l_Mcb1
Mff1 out p1 vdd vdd pmos W=w_Mff1 L=l_Mff1

Ccb1 out n_cb_3 c=c_Ccb1
Riac1 p3 n_iac_4 r=r_Riac1
Ciac1 n_iac_4 gnd c=c_Ciac1
CL out gnd c=c_CL
.ENDS CKTCASE
