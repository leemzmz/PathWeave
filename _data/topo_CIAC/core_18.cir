*auto-generated subcircuit netlist (from TopoGen)
.SUBCKT CKTCASE ipos ineg out b0 b1 b2 b3 b4 vdd gnd
*.PININFO ipos:I ineg:I out:O b0:B b1:B b2:B b3:B b4:B vdd:B gnd:B

Mn1 p1 ipos n_tail_2 gnd nmos W=w_Mn1 L=l_Mn1
Mn2 n_diff_1 ineg n_tail_2 gnd nmos W=w_Mn2 L=l_Mn2
Mp1 p1 n_diff_1 vdd vdd pmos W=w_Mp1 L=l_Mp1
Mp2 n_diff_1 n_diff_1 vdd vdd pmos W=w_Mp2 L=l_Mp2
Mtail1 n_tail_2 b0 n_rail_3 gnd nmos W=w_Mtail1 L=l_Mtail1
Mtail2 n_rail_3 b1 gnd gnd nmos W=w_Mtail2 L=l_Mtail2
Mn3 p2 p1 gnd gnd nmos W=w_Mn3 L=l_Mn3
Mref1 p2 p2 vdd vdd pmos W=w_Mref1 L=l_Mref1
Mmirror1 p3 p2 vdd vdd pmos W=w_Mmirror1 L=l_Mmirror1
Msupport1 p3 b2 gnd gnd nmos W=w_Msupport1 L=l_Msupport1
Mp3 out p3 vdd vdd pmos W=w_Mp3 L=l_Mp3
Mn4 out b3 gnd gnd nmos W=w_Mn4 L=l_Mn4
Mcb1 p1 b4 n_cb_4 gnd nmos W=w_Mcb1 L=l_Mcb1
Mff1 out p1 gnd gnd nmos W=w_Mff1 L=l_Mff1

Ccb1 out n_cb_4 c=c_Ccb1
Riac1 p3 n_iac_5 r=r_Riac1
Ciac1 n_iac_5 gnd c=c_Ciac1
CL out gnd c=c_CL
.ENDS CKTCASE
