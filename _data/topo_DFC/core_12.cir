*auto-generated subcircuit netlist (from TopoGen)
.SUBCKT CKTCASE ipos ineg out b0 b1 b2 b3 b4 b5 vdd gnd
*.PININFO ipos:I ineg:I out:O b0:B b1:B b2:B b3:B b4:B b5:B vdd:B gnd:B

Mn1 p1 ipos n_tail_2 gnd nmos W=w_Mn1 L=l_Mn1
Mn2 n_diff_1 ineg n_tail_2 gnd nmos W=w_Mn2 L=l_Mn2
Mp1 p1 n_diff_1 vdd vdd pmos W=w_Mp1 L=l_Mp1
Mp2 n_diff_1 n_diff_1 vdd vdd pmos W=w_Mp2 L=l_Mp2
Mtail1 n_tail_2 b0 n_rail_3 gnd nmos W=w_Mtail1 L=l_Mtail1
Mtail2 n_rail_3 b1 gnd gnd nmos W=w_Mtail2 L=l_Mtail2
Mp3 n_series_4 p1 vdd vdd pmos W=w_Mp3 L=l_Mp3
Mp4 n_series_5 b2 n_series_4 vdd pmos W=w_Mp4 L=l_Mp4
Mp5 out b3 n_series_5 vdd pmos W=w_Mp5 L=l_Mp5
Mn3 out b4 gnd gnd nmos W=w_Mn3 L=l_Mn3
Mdfc1 n_dfc_6 out gnd gnd nmos W=w_Mdfc1 L=l_Mdfc1
Mp6 n_dfc_6 b5 vdd vdd pmos W=w_Mp6 L=l_Mp6

Cdfc1 n_dfc_6 out c=c_Cdfc1
CL out gnd c=c_CL
.ENDS CKTCASE
