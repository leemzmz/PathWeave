*auto-generated subcircuit netlist (from TopoGen)
.SUBCKT CKTCASE ipos ineg out b0 b1 b2 b3 b4 b5 vdd gnd
*.PININFO ipos:I ineg:I out:O b0:B b1:B b2:B b3:B b4:B b5:B vdd:B gnd:B

Mp1 p1 ipos n_tail_2 vdd pmos W=w_Mp1 L=l_Mp1
Mp2 n_diff_1 ineg n_tail_2 vdd pmos W=w_Mp2 L=l_Mp2
Mn1 p1 n_diff_1 gnd gnd nmos W=w_Mn1 L=l_Mn1
Mn2 n_diff_1 n_diff_1 gnd gnd nmos W=w_Mn2 L=l_Mn2
Mtail1 n_tail_2 b0 n_rail_3 vdd pmos W=w_Mtail1 L=l_Mtail1
Mtail2 n_rail_3 b1 vdd vdd pmos W=w_Mtail2 L=l_Mtail2
Mn3 n_series_4 p1 gnd gnd nmos W=w_Mn3 L=l_Mn3
Mn4 n_series_5 b2 n_series_4 gnd nmos W=w_Mn4 L=l_Mn4
Mn5 out b3 n_series_5 gnd nmos W=w_Mn5 L=l_Mn5
Mp3 out b4 vdd vdd pmos W=w_Mp3 L=l_Mp3
Mdfc1 n_dfc_6 out gnd gnd nmos W=w_Mdfc1 L=l_Mdfc1
Mp4 n_dfc_6 b5 vdd vdd pmos W=w_Mp4 L=l_Mp4

Cdfc1 n_dfc_6 out c=c_Cdfc1
CL out gnd c=c_CL
.ENDS CKTCASE
