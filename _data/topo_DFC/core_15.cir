*auto-generated subcircuit netlist (from TopoGen)
.SUBCKT CKTCASE ipos ineg out b0 b1 b2 b3 vdd gnd
*.PININFO ipos:I ineg:I out:O b0:B b1:B b2:B b3:B vdd:B gnd:B

Mp1 p1 ipos n_tail_2 vdd pmos W=w_Mp1 L=l_Mp1
Mp2 n_diff_1 ineg n_tail_2 vdd pmos W=w_Mp2 L=l_Mp2
Mn1 p1 n_diff_1 gnd gnd nmos W=w_Mn1 L=l_Mn1
Mn2 n_diff_1 n_diff_1 gnd gnd nmos W=w_Mn2 L=l_Mn2
Mtail1 n_tail_2 b0 n_rail_3 vdd pmos W=w_Mtail1 L=l_Mtail1
Mtail2 n_rail_3 b1 vdd vdd pmos W=w_Mtail2 L=l_Mtail2
Mp3 out p1 vdd vdd pmos W=w_Mp3 L=l_Mp3
Mn3 out b2 gnd gnd nmos W=w_Mn3 L=l_Mn3
Mdfc1 n_dfc_4 out vdd vdd pmos W=w_Mdfc1 L=l_Mdfc1
Mn4 n_dfc_4 b3 gnd gnd nmos W=w_Mn4 L=l_Mn4

Cdfc1 n_dfc_4 out c=c_Cdfc1
CL out gnd c=c_CL
.ENDS CKTCASE
