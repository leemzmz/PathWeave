*auto-generated subcircuit netlist (from TopoGen)
.SUBCKT CKTCASE ipos ineg out b0 b1 b2 b3 b4 b5 b6 vdd gnd
*.PININFO ipos:I ineg:I out:O b0:B b1:B b2:B b3:B b4:B b5:B b6:B vdd:B gnd:B

Mp1 p1 ipos n_tail_2 vdd pmos W=w_Mp1 L=l_Mp1
Mp2 n_diff_1 ineg n_tail_2 vdd pmos W=w_Mp2 L=l_Mp2
Mn1 p1 n_diff_1 gnd gnd nmos W=w_Mn1 L=l_Mn1
Mn2 n_diff_1 n_diff_1 gnd gnd nmos W=w_Mn2 L=l_Mn2
Mtail1 n_tail_2 b0 vdd vdd pmos W=w_Mtail1 L=l_Mtail1
Mp3 p2 p1 vdd vdd pmos W=w_Mp3 L=l_Mp3
Mref1 p2 p2 gnd gnd nmos W=w_Mref1 L=l_Mref1
Mmirror1 p3 p2 gnd gnd nmos W=w_Mmirror1 L=l_Mmirror1
Msupport1 p3 b1 vdd vdd pmos W=w_Msupport1 L=l_Msupport1
Mn3 n_series_3 p3 gnd gnd nmos W=w_Mn3 L=l_Mn3
Mn4 n_series_4 b2 n_series_3 gnd nmos W=w_Mn4 L=l_Mn4
Mn5 out b3 n_series_4 gnd nmos W=w_Mn5 L=l_Mn5
Mp4 out b4 vdd vdd pmos W=w_Mp4 L=l_Mp4
Mcb1 p1 b5 n_cb_5 gnd nmos W=w_Mcb1 L=l_Mcb1
Mcb2 p3 b6 n_cb_6 gnd nmos W=w_Mcb2 L=l_Mcb2

Ccb1 out n_cb_5 c=c_Ccb1
Ccb2 out n_cb_6 c=c_Ccb2
CL out gnd c=c_CL
.ENDS CKTCASE
