*auto-generated subcircuit netlist (from TopoGen)
.SUBCKT CKTCASE ipos ineg out b0 b1 b2 b3 b4 b5 b6 vdd gnd
*.PININFO ipos:I ineg:I out:O b0:B b1:B b2:B b3:B b4:B b5:B b6:B vdd:B gnd:B

Mn1 p1 ipos n_tail_2 gnd nmos W=w_Mn1 L=l_Mn1
Mn2 n_diff_1 ineg n_tail_2 gnd nmos W=w_Mn2 L=l_Mn2
Mp1 p1 n_diff_1 vdd vdd pmos W=w_Mp1 L=l_Mp1
Mp2 n_diff_1 n_diff_1 vdd vdd pmos W=w_Mp2 L=l_Mp2
Mtail1 n_tail_2 b0 gnd gnd nmos W=w_Mtail1 L=l_Mtail1
Mn3 p2 p1 gnd gnd nmos W=w_Mn3 L=l_Mn3
Mp3 p2 b1 vdd vdd pmos W=w_Mp3 L=l_Mp3
Mp4 n_series_3 p2 vdd vdd pmos W=w_Mp4 L=l_Mp4
Mp5 n_series_4 b2 n_series_3 vdd pmos W=w_Mp5 L=l_Mp5
Mp6 p3 b3 n_series_4 vdd pmos W=w_Mp6 L=l_Mp6
Mref1 p3 p3 gnd gnd nmos W=w_Mref1 L=l_Mref1
Mmirror1 out p3 gnd gnd nmos W=w_Mmirror1 L=l_Mmirror1
Msupport1 out b4 n_rail_5 vdd pmos W=w_Msupport1 L=l_Msupport1
Msupport2 n_rail_5 b5 n_rail_6 vdd pmos W=w_Msupport2 L=l_Msupport2
Msupport3 n_rail_6 b6 vdd vdd pmos W=w_Msupport3 L=l_Msupport3
Mffmirror1 out n_diff_1 vdd vdd pmos W=w_Mffmirror1 L=l_Mffmirror1

Rc1 p2 n_nr_7 r=r_Rc1
Cc1 n_nr_7 p1 c=c_Cc1
Rc2 out n_nr_8 r=r_Rc2
Cc2 n_nr_8 p1 c=c_Cc2
CL out gnd c=c_CL
.ENDS CKTCASE
