*auto-generated subcircuit netlist (from TopoGen)
.SUBCKT CKTCASE vref vfb vout b0 b1 b2 vdd gnd
*.PININFO vref:I vfb:I vout:O b0:B b1:B b2:B vdd:B gnd:B

Mp1 p1 vref n_tail_2 vdd pmos W=w_Mp1 L=l_Mp1
Mp2 n_diff_1 vfb n_tail_2 vdd pmos W=w_Mp2 L=l_Mp2
Mn1 p1 n_diff_1 gnd gnd nmos W=w_Mn1 L=l_Mn1
Mn2 n_diff_1 n_diff_1 gnd gnd nmos W=w_Mn2 L=l_Mn2
Mtail1 n_tail_2 b0 vdd vdd pmos W=w_Mtail1 L=l_Mtail1
Mp3 p2 p1 vdd vdd pmos W=w_Mp3 L=l_Mp3
Mref1 p2 p2 gnd gnd nmos W=w_Mref1 L=l_Mref1
Mmirror1 p3 p2 gnd gnd nmos W=w_Mmirror1 L=l_Mmirror1
Msupport1 p3 b1 vdd vdd pmos W=w_Msupport1 L=l_Msupport1
Mpass1 vout p3 vdd vdd pmos W=w_Mpass1 L=l_Mpass1
Mcb1 p1 b2 n_cb_3 gnd nmos W=w_Mcb1 L=l_Mcb1
Mff1 p3 p1 gnd gnd nmos W=w_Mff1 L=l_Mff1
Mgf1 vout vout vfb gnd nmos W=w_Mgf1 L=l_Mgf1
Mgf2 vfb vfb gnd gnd nmos W=w_Mgf2 L=l_Mgf2

Ccb1 vout n_cb_3 c=c_Ccb1
CL vout gnd c=c_CL
.ENDS CKTCASE
