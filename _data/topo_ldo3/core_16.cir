*auto-generated subcircuit netlist (from TopoGen)
.SUBCKT CKTCASE vref vfb vout b0 b1 b2 b3 b4 b5 b6 b7 vdd gnd
*.PININFO vref:I vfb:I vout:O b0:B b1:B b2:B b3:B b4:B b5:B b6:B b7:B vdd:B gnd:B

Mp1 p1 vref n_tail_2 vdd pmos W=w_Mp1 L=l_Mp1
Mp2 n_diff_1 vfb n_tail_2 vdd pmos W=w_Mp2 L=l_Mp2
Mn1 p1 n_diff_1 gnd gnd nmos W=w_Mn1 L=l_Mn1
Mn2 n_diff_1 n_diff_1 gnd gnd nmos W=w_Mn2 L=l_Mn2
Mtail1 n_tail_2 b0 n_rail_3 vdd pmos W=w_Mtail1 L=l_Mtail1
Mtail2 n_rail_3 b1 vdd vdd pmos W=w_Mtail2 L=l_Mtail2
Mp3 p2 p1 vdd vdd pmos W=w_Mp3 L=l_Mp3
Mn3 p2 b2 gnd gnd nmos W=w_Mn3 L=l_Mn3
Mp4 n_series_4 p2 vdd vdd pmos W=w_Mp4 L=l_Mp4
Mp5 n_series_5 b3 n_series_4 vdd pmos W=w_Mp5 L=l_Mp5
Mp6 p3 b4 n_series_5 vdd pmos W=w_Mp6 L=l_Mp6
Mref1 p3 p3 gnd gnd nmos W=w_Mref1 L=l_Mref1
Mmirror1 p4 p3 gnd gnd nmos W=w_Mmirror1 L=l_Mmirror1
Msupport1 p4 b5 n_rail_6 vdd pmos W=w_Msupport1 L=l_Msupport1
Msupport2 n_rail_6 b6 n_rail_7 vdd pmos W=w_Msupport2 L=l_Msupport2
Msupport3 n_rail_7 b7 vdd vdd pmos W=w_Msupport3 L=l_Msupport3
Mpass1 vout p4 vdd vdd pmos W=w_Mpass1 L=l_Mpass1
Mffmirror1 p3 n_diff_1 gnd gnd nmos W=w_Mffmirror1 L=l_Mffmirror1
Mgf1 vout vout vfb gnd nmos W=w_Mgf1 L=l_Mgf1
Mgf2 vfb vfb gnd gnd nmos W=w_Mgf2 L=l_Mgf2

Rc1 p2 n_nr_8 r=r_Rc1
Cc1 n_nr_8 p1 c=c_Cc1
Cc2 vout p1 c=c_Cc2
CL vout gnd c=c_CL
.ENDS CKTCASE
