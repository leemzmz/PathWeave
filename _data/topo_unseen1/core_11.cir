*auto-generated subcircuit netlist (from TopoGen)
.SUBCKT CKTCASE ipos ineg out b0 b1 b2 b3 b4 b5 b6 b7 vdd gnd
*.PININFO ipos:I ineg:I out:O b0:B b1:B b2:B b3:B b4:B b5:B b6:B b7:B vdd:B gnd:B

Mn1 p1 ipos n_tail_2 gnd nmos W=w_Mn1 L=l_Mn1
Mn2 n_diff_1 ineg n_tail_2 gnd nmos W=w_Mn2 L=l_Mn2
Mp1 p1 n_diff_1 vdd vdd pmos W=w_Mp1 L=l_Mp1
Mp2 n_diff_1 n_diff_1 vdd vdd pmos W=w_Mp2 L=l_Mp2
Mtail1 n_tail_2 b0 gnd gnd nmos W=w_Mtail1 L=l_Mtail1
Mp3 n_series_3 p1 vdd vdd pmos W=w_Mp3 L=l_Mp3
Mp4 n_series_4 b1 n_series_3 vdd pmos W=w_Mp4 L=l_Mp4
Mp5 p2 b2 n_series_4 vdd pmos W=w_Mp5 L=l_Mp5
Mn3 p2 b3 gnd gnd nmos W=w_Mn3 L=l_Mn3
Mp6 n_series_5 p2 vdd vdd pmos W=w_Mp6 L=l_Mp6
Mp7 p3 b4 n_series_5 vdd pmos W=w_Mp7 L=l_Mp7
Mref1 p3 p3 gnd gnd nmos W=w_Mref1 L=l_Mref1
Mmirror1 out p3 gnd gnd nmos W=w_Mmirror1 L=l_Mmirror1
Msupport1 out b5 n_rail_6 vdd pmos W=w_Msupport1 L=l_Msupport1
Msupport2 n_rail_6 b6 vdd vdd pmos W=w_Msupport2 L=l_Msupport2
Mvb1 n_vb_8 p3 gnd gnd nmos W=w_Mvb1 L=l_Mvb1
Mp8 n_vb_8 b7 vdd vdd pmos W=w_Mp8 L=l_Mp8
Mffmirror1 p3 n_diff_1 vdd vdd pmos W=w_Mffmirror1 L=l_Mffmirror1

Rc1 p2 n_nr_7 r=r_Rc1
Cc1 n_nr_7 p1 c=c_Cc1
Cvb1 n_vb_8 p1 c=c_Cvb1
CL out gnd c=c_CL
.ENDS CKTCASE
