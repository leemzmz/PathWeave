*auto-generated subcircuit netlist (from TopoGen)
.SUBCKT CKTCASE ipos ineg out b0 b1 b2 b3 b4 b5 b6 vdd gnd
*.PININFO ipos:I ineg:I out:O b0:B b1:B b2:B b3:B b4:B b5:B b6:B vdd:B gnd:B

Mn1 p1 ipos n_tail_2 gnd nmos W=w_Mn1 L=l_Mn1
Mn2 n_diff_1 ineg n_tail_2 gnd nmos W=w_Mn2 L=l_Mn2
Mp1 p1 n_diff_1 vdd vdd pmos W=w_Mp1 L=l_Mp1
Mp2 n_diff_1 n_diff_1 vdd vdd pmos W=w_Mp2 L=l_Mp2
Mtail1 n_tail_2 b0 gnd gnd nmos W=w_Mtail1 L=l_Mtail1
Mn3 n_series_3 p1 gnd gnd nmos W=w_Mn3 L=l_Mn3
Mn4 p2 b1 n_series_3 gnd nmos W=w_Mn4 L=l_Mn4
Mp3 p2 b2 vdd vdd pmos W=w_Mp3 L=l_Mp3
Mn5 n_series_4 p2 gnd gnd nmos W=w_Mn5 L=l_Mn5
Mn6 p3 b3 n_series_4 gnd nmos W=w_Mn6 L=l_Mn6
Mref1 p3 p3 vdd vdd pmos W=w_Mref1 L=l_Mref1
Mmirror1 out p3 vdd vdd pmos W=w_Mmirror1 L=l_Mmirror1
Msupport1 out b4 n_rail_5 gnd nmos W=w_Msupport1 L=l_Msupport1
Msupport2 n_rail_5 b5 gnd gnd nmos W=w_Msupport2 L=l_Msupport2
Mvb1 n_vb_7 p3 vdd vdd pmos W=w_Mvb1 L=l_Mvb1
Mn7 n_vb_7 b6 gnd gnd nmos W=w_Mn7 L=l_Mn7
Mffmirror1 p3 n_diff_1 vdd vdd pmos W=w_Mffmirror1 L=l_Mffmirror1

Rc1 p2 n_nr_6 r=r_Rc1
Cc1 n_nr_6 p1 c=c_Cc1
Cvb1 n_vb_7 p1 c=c_Cvb1
CL out gnd c=c_CL
.ENDS CKTCASE
