*auto-generated subcircuit netlist (from TopoGen)
.SUBCKT CKTCASE ipos ineg out b0 b1 b2 b3 b4 b5 vdd gnd
*.PININFO ipos:I ineg:I out:O b0:B b1:B b2:B b3:B b4:B b5:B vdd:B gnd:B

Mn1 p1 ipos n_tail_2 gnd nmos W=w_Mn1 L=l_Mn1
Mn2 n_diff_1 ineg n_tail_2 gnd nmos W=w_Mn2 L=l_Mn2
Mp1 p1 n_diff_1 vdd vdd pmos W=w_Mp1 L=l_Mp1
Mp2 n_diff_1 n_diff_1 vdd vdd pmos W=w_Mp2 L=l_Mp2
Mtail1 n_tail_2 b0 n_rail_3 gnd nmos W=w_Mtail1 L=l_Mtail1
Mtail2 n_rail_3 b1 gnd gnd nmos W=w_Mtail2 L=l_Mtail2
Mn3 p2 p1 gnd gnd nmos W=w_Mn3 L=l_Mn3
Mref1 p2 p2 vdd vdd pmos W=w_Mref1 L=l_Mref1
Mmirror1 p3 p2 vdd vdd pmos W=w_Mmirror1 L=l_Mmirror1
Msupport1 p3 b2 gnd gnd nmos W=w_Msupport1 L=l_Msupport1
Mp3 out p3 vdd vdd pmos W=w_Mp3 L=l_Mp3
Mn4 out b3 gnd gnd nmos W=w_Mn4 L=l_Mn4
Macb1 n_acb_4 p2 vdd vdd pmos W=w_Macb1 L=l_Macb1
Mn5 n_acb_4 b4 gnd gnd nmos W=w_Mn5 L=l_Mn5
Mvb1 n_vb_5 p3 gnd gnd nmos W=w_Mvb1 L=l_Mvb1
Mp4 n_vb_5 b5 vdd vdd pmos W=w_Mp4 L=l_Mp4
Mff1 p3 ipos vdd vdd pmos W=w_Mff1 L=l_Mff1

Cacb1 n_acb_4 p3 c=c_Cacb1
Cvb1 n_vb_5 p1 c=c_Cvb1
CL out gnd c=c_CL
.ENDS CKTCASE
