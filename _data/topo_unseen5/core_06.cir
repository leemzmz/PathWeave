*auto-generated subcircuit netlist (from TopoGen)
.SUBCKT CKTCASE ipos ineg out b0 b1 b2 b3 b4 b5 b6 b7 vdd gnd
*.PININFO ipos:I ineg:I out:O b0:B b1:B b2:B b3:B b4:B b5:B b6:B b7:B vdd:B gnd:B

Mp1 p1 ipos n_tail_2 vdd pmos W=w_Mp1 L=l_Mp1
Mp2 n_diff_1 ineg n_tail_2 vdd pmos W=w_Mp2 L=l_Mp2
Mn1 p1 n_diff_1 gnd gnd nmos W=w_Mn1 L=l_Mn1
Mn2 n_diff_1 n_diff_1 gnd gnd nmos W=w_Mn2 L=l_Mn2
Mtail1 n_tail_2 b0 vdd vdd pmos W=w_Mtail1 L=l_Mtail1
Mp3 p2 p1 vdd vdd pmos W=w_Mp3 L=l_Mp3
Mn3 p2 b1 gnd gnd nmos W=w_Mn3 L=l_Mn3
Mn4 n_series_3 p2 gnd gnd nmos W=w_Mn4 L=l_Mn4
Mn5 n_series_4 b2 n_series_3 gnd nmos W=w_Mn5 L=l_Mn5
Mn6 p3 b3 n_series_4 gnd nmos W=w_Mn6 L=l_Mn6
Mref1 p3 p3 vdd vdd pmos W=w_Mref1 L=l_Mref1
Mmirror1 out p3 vdd vdd pmos W=w_Mmirror1 L=l_Mmirror1
Msupport1 out b4 n_rail_5 gnd nmos W=w_Msupport1 L=l_Msupport1
Msupport2 n_rail_5 b5 n_rail_6 gnd nmos W=w_Msupport2 L=l_Msupport2
Msupport3 n_rail_6 b6 gnd gnd nmos W=w_Msupport3 L=l_Msupport3
Macb1 n_acb_9 p1 vdd vdd pmos W=w_Macb1 L=l_Macb1
Mn7 n_acb_9 b7 gnd gnd nmos W=w_Mn7 L=l_Mn7
Mff1 p2 ipos gnd gnd nmos W=w_Mff1 L=l_Mff1

Riac1 p2 n_iac_7 r=r_Riac1
Ciac1 n_iac_7 gnd c=c_Ciac1
Rc1 out n_nr_8 r=r_Rc1
Cc1 n_nr_8 p1 c=c_Cc1
Cacb1 n_acb_9 p3 c=c_Cacb1
CL out gnd c=c_CL
.ENDS CKTCASE
