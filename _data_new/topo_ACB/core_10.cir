*auto-generated subcircuit netlist (from TopoGen)
.SUBCKT CKTCASE ipos ineg out b0 b1 b2 b3 b4 vdd gnd
*.PININFO ipos:I ineg:I out:O b0:B b1:B b2:B b3:B b4:B vdd:B gnd:B

Mn1 p1 ipos n_tail_1 gnd nmos W=w_Mn1 L=l_Mn1
Mn2 n_diff_2 ineg n_tail_1 gnd nmos W=w_Mn2 L=l_Mn2
Mtail1 n_tail_1 b0 n_rail_3 gnd nmos W=w_Mtail1 L=l_Mtail1
Mtail2 n_rail_3 b1 gnd gnd nmos W=w_Mtail2 L=l_Mtail2
MloadRef1 n_diff_2 n_diff_2 vdd vdd pmos W=w_MloadRef1 L=l_MloadRef1
MloadMirror1 p1 n_diff_2 vdd vdd pmos W=w_MloadMirror1 L=l_MloadMirror1
Mn3 n_series_4 p1 gnd gnd nmos W=w_Mn3 L=l_Mn3
Mn4 out b2 n_series_4 gnd nmos W=w_Mn4 L=l_Mn4
Mp1 out b3 vdd vdd pmos W=w_Mp1 L=l_Mp1
Macb1 n_acb_5 p1 gnd gnd nmos W=w_Macb1 L=l_Macb1
Mp2 n_acb_5 b4 vdd vdd pmos W=w_Mp2 L=l_Mp2

Cacb1 n_acb_5 out c=c_Cacb1
CL out gnd c=c_CL
.ENDS CKTCASE
