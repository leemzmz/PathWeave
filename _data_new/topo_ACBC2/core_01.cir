*auto-generated subcircuit netlist (from TopoGen)
.SUBCKT CKTCASE ipos ineg out b0 b1 b2 b3 b4 b5 b6 vdd gnd
*.PININFO ipos:I ineg:I out:O b0:B b1:B b2:B b3:B b4:B b5:B b6:B vdd:B gnd:B

Mp1 p1 ipos n_tail_1 vdd pmos W=w_Mp1 L=l_Mp1
Mp2 n_diff_2 ineg n_tail_1 vdd pmos W=w_Mp2 L=l_Mp2
Mtail1 n_tail_1 b0 vdd vdd pmos W=w_Mtail1 L=l_Mtail1
MloadCas1 n_diff_2 b1 n_load_3 gnd nmos W=w_MloadCas1 L=l_MloadCas1
MloadCas2 p1 b1 n_load_4 gnd nmos W=w_MloadCas2 L=l_MloadCas2
MloadRef1 n_load_3 n_load_3 gnd gnd nmos W=w_MloadRef1 L=l_MloadRef1
MloadMirror1 n_load_4 n_load_3 gnd gnd nmos W=w_MloadMirror1 L=l_MloadMirror1
Mp3 n_series_5 p1 vdd vdd pmos W=w_Mp3 L=l_Mp3
Mp4 p2 b2 n_series_5 vdd pmos W=w_Mp4 L=l_Mp4
Mref1 p2 p2 gnd gnd nmos W=w_Mref1 L=l_Mref1
Mmirror1 p3 p2 gnd gnd nmos W=w_Mmirror1 L=l_Mmirror1
Msupport1 p3 b3 n_rail_6 vdd pmos W=w_Msupport1 L=l_Msupport1
Msupport2 n_rail_6 b4 vdd vdd pmos W=w_Msupport2 L=l_Msupport2
Mn1 out p3 gnd gnd nmos W=w_Mn1 L=l_Mn1
Mp5 out b5 vdd vdd pmos W=w_Mp5 L=l_Mp5
Mffmirror1 out n_load_3 gnd gnd nmos W=w_Mffmirror1 L=l_Mffmirror1
Macb1 n_acb_7 p2 gnd gnd nmos W=w_Macb1 L=l_Macb1
Mp6 n_acb_7 b6 vdd vdd pmos W=w_Mp6 L=l_Mp6

Cc1 out p1 c=c_Cc1
Cacb1 n_acb_7 p3 c=c_Cacb1
CL out gnd c=c_CL
.ENDS CKTCASE
