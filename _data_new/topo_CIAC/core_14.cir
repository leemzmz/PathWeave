*auto-generated subcircuit netlist (from TopoGen)
.SUBCKT CKTCASE ipos ineg out b0 b1 b2 b3 b4 b5 b6 b7 b8 b9 b10 vdd gnd
*.PININFO ipos:I ineg:I out:O b0:B b1:B b2:B b3:B b4:B b5:B b6:B b7:B b8:B b9:B b10:B vdd:B gnd:B

Mp1 p1 ipos n_tail_1 vdd pmos W=w_Mp1 L=l_Mp1
Mp2 n_diff_2 ineg n_tail_1 vdd pmos W=w_Mp2 L=l_Mp2
Mtail1 n_tail_1 b0 n_rail_3 vdd pmos W=w_Mtail1 L=l_Mtail1
Mtail2 n_rail_3 b1 vdd vdd pmos W=w_Mtail2 L=l_Mtail2
MloadRef1 n_diff_2 n_diff_2 gnd gnd nmos W=w_MloadRef1 L=l_MloadRef1
MloadMirror1 p1 n_diff_2 gnd gnd nmos W=w_MloadMirror1 L=l_MloadMirror1
Mp3 n_series_4 p1 vdd vdd pmos W=w_Mp3 L=l_Mp3
Mp4 n_series_5 b2 n_series_4 vdd pmos W=w_Mp4 L=l_Mp4
Mp5 p2 b3 n_series_5 vdd pmos W=w_Mp5 L=l_Mp5
Mref1 p2 p2 gnd gnd nmos W=w_Mref1 L=l_Mref1
Mmirror1 p3 p2 gnd gnd nmos W=w_Mmirror1 L=l_Mmirror1
Msupport1 p3 b4 n_rail_6 vdd pmos W=w_Msupport1 L=l_Msupport1
Msupport2 n_rail_6 b5 n_rail_7 vdd pmos W=w_Msupport2 L=l_Msupport2
Msupport3 n_rail_7 b6 vdd vdd pmos W=w_Msupport3 L=l_Msupport3
Mp6 n_series_8 p3 vdd vdd pmos W=w_Mp6 L=l_Mp6
Mp7 n_series_9 b7 n_series_8 vdd pmos W=w_Mp7 L=l_Mp7
Mp8 out b8 n_series_9 vdd pmos W=w_Mp8 L=l_Mp8
Mn1 out b9 gnd gnd nmos W=w_Mn1 L=l_Mn1
Mcb1 p1 b10 n_cb_10 gnd nmos W=w_Mcb1 L=l_Mcb1
Mffmirror1 out n_diff_2 gnd gnd nmos W=w_Mffmirror1 L=l_Mffmirror1

Ccb1 out n_cb_10 c=c_Ccb1
Riac1 p3 n_iac_11 r=r_Riac1
Ciac1 n_iac_11 gnd c=c_Ciac1
CL out gnd c=c_CL
.ENDS CKTCASE
