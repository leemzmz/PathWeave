*auto-generated subcircuit netlist (from TopoGen)
.SUBCKT CKTCASE ipos ineg out b0 b1 b2 b3 b4 vdd gnd
*.PININFO ipos:I ineg:I out:O b0:B b1:B b2:B b3:B b4:B vdd:B gnd:B

Mn1 p1 ipos n_tail_1 gnd nmos W=w_Mn1 L=l_Mn1
Mn2 n_diff_2 ineg n_tail_1 gnd nmos W=w_Mn2 L=l_Mn2
Mtail1 n_tail_1 b0 gnd gnd nmos W=w_Mtail1 L=l_Mtail1
MloadCas1 n_diff_2 b1 n_load_3 vdd pmos W=w_MloadCas1 L=l_MloadCas1
MloadCas2 p1 b1 n_load_4 vdd pmos W=w_MloadCas2 L=l_MloadCas2
MloadRef1 n_load_3 n_load_3 vdd vdd pmos W=w_MloadRef1 L=l_MloadRef1
MloadMirror1 n_load_4 n_load_3 vdd vdd pmos W=w_MloadMirror1 L=l_MloadMirror1
Mn3 n_series_5 p1 gnd gnd nmos W=w_Mn3 L=l_Mn3
Mn4 out b2 n_series_5 gnd nmos W=w_Mn4 L=l_Mn4
Mp1 out b3 vdd vdd pmos W=w_Mp1 L=l_Mp1
Mdfc1 n_dfc_6 out gnd gnd nmos W=w_Mdfc1 L=l_Mdfc1
Mp2 n_dfc_6 b4 vdd vdd pmos W=w_Mp2 L=l_Mp2

Cdfc1 n_dfc_6 out c=c_Cdfc1
CL out gnd c=c_CL
.ENDS CKTCASE
