*auto-generated subcircuit netlist (from TopoGen)
.SUBCKT CKTCASE ipos ineg out b0 b1 b2 b3 b4 b5 b6 vdd gnd
*.PININFO ipos:I ineg:I out:O b0:B b1:B b2:B b3:B b4:B b5:B b6:B vdd:B gnd:B

Mp1 n_diff_2 ipos n_tail_1 vdd pmos W=w_Mp1 L=l_Mp1
Mp2 n_diff_3 ineg n_tail_1 vdd pmos W=w_Mp2 L=l_Mp2
Mtail1 n_tail_1 b0 vdd vdd pmos W=w_Mtail1 L=l_Mtail1
MfoldSource1 n_diff_2 b1 gnd gnd nmos W=w_MfoldSource1 L=l_MfoldSource1
MfoldSource2 n_diff_3 b1 gnd gnd nmos W=w_MfoldSource2 L=l_MfoldSource2
Mfold1 p1 b2 n_diff_2 gnd nmos W=w_Mfold1 L=l_Mfold1
Mfold2 n_fold_4 b2 n_diff_3 gnd nmos W=w_Mfold2 L=l_Mfold2
MloadRef1 n_fold_4 n_fold_4 vdd vdd pmos W=w_MloadRef1 L=l_MloadRef1
MloadMirror1 p1 n_fold_4 vdd vdd pmos W=w_MloadMirror1 L=l_MloadMirror1
Mp3 n_series_5 p1 vdd vdd pmos W=w_Mp3 L=l_Mp3
Mp4 n_series_6 b3 n_series_5 vdd pmos W=w_Mp4 L=l_Mp4
Mp5 out b4 n_series_6 vdd pmos W=w_Mp5 L=l_Mp5
Mn1 out b5 gnd gnd nmos W=w_Mn1 L=l_Mn1
Mdfc1 n_dfc_7 out vdd vdd pmos W=w_Mdfc1 L=l_Mdfc1
Mn2 n_dfc_7 b6 gnd gnd nmos W=w_Mn2 L=l_Mn2

Cdfc1 n_dfc_7 out c=c_Cdfc1
CL out gnd c=c_CL
.ENDS CKTCASE
