*auto-generated subcircuit netlist (from TopoGen)
.SUBCKT CKTCASE ipos ineg out b0 b1 b2 b3 b4 b5 b6 b7 vdd gnd
*.PININFO ipos:I ineg:I out:O b0:B b1:B b2:B b3:B b4:B b5:B b6:B b7:B vdd:B gnd:B

Mn1 n_diff_2 ipos n_tail_1 gnd nmos W=w_Mn1 L=l_Mn1
Mn2 n_diff_3 ineg n_tail_1 gnd nmos W=w_Mn2 L=l_Mn2
Mtail1 n_tail_1 b0 gnd gnd nmos W=w_Mtail1 L=l_Mtail1
MfoldSource1 n_diff_2 b1 vdd vdd pmos W=w_MfoldSource1 L=l_MfoldSource1
MfoldSource2 n_diff_3 b1 vdd vdd pmos W=w_MfoldSource2 L=l_MfoldSource2
Mfold1 p1 b2 n_diff_2 vdd pmos W=w_Mfold1 L=l_Mfold1
Mfold2 n_fold_4 b2 n_diff_3 vdd pmos W=w_Mfold2 L=l_Mfold2
MloadCas1 n_fold_4 b3 n_load_5 gnd nmos W=w_MloadCas1 L=l_MloadCas1
MloadCas2 p1 b3 n_load_6 gnd nmos W=w_MloadCas2 L=l_MloadCas2
MloadRef1 n_load_5 n_load_5 gnd gnd nmos W=w_MloadRef1 L=l_MloadRef1
MloadMirror1 n_load_6 n_load_5 gnd gnd nmos W=w_MloadMirror1 L=l_MloadMirror1
Mp1 n_series_7 p1 vdd vdd pmos W=w_Mp1 L=l_Mp1
Mp2 n_series_8 b4 n_series_7 vdd pmos W=w_Mp2 L=l_Mp2
Mp3 out b5 n_series_8 vdd pmos W=w_Mp3 L=l_Mp3
Mn3 out b6 gnd gnd nmos W=w_Mn3 L=l_Mn3
Mdfc1 n_dfc_9 out vdd vdd pmos W=w_Mdfc1 L=l_Mdfc1
Mn4 n_dfc_9 b7 gnd gnd nmos W=w_Mn4 L=l_Mn4

Cdfc1 n_dfc_9 out c=c_Cdfc1
CL out gnd c=c_CL
.ENDS CKTCASE
