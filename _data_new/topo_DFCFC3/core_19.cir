*auto-generated subcircuit netlist (from TopoGen)
.SUBCKT CKTCASE ipos ineg out b0 b1 b2 b3 b4 b5 vdd gnd
*.PININFO ipos:I ineg:I out:O b0:B b1:B b2:B b3:B b4:B b5:B vdd:B gnd:B

Mn1 p1 ipos n_tail_1 gnd nmos W=w_Mn1 L=l_Mn1
Mn2 n_diff_2 ineg n_tail_1 gnd nmos W=w_Mn2 L=l_Mn2
Mtail1 n_tail_1 b0 n_rail_3 gnd nmos W=w_Mtail1 L=l_Mtail1
Mtail2 n_rail_3 b1 gnd gnd nmos W=w_Mtail2 L=l_Mtail2
MloadRef1 n_diff_2 n_diff_2 vdd vdd pmos W=w_MloadRef1 L=l_MloadRef1
MloadMirror1 p1 n_diff_2 vdd vdd pmos W=w_MloadMirror1 L=l_MloadMirror1
Mn3 p2 p1 gnd gnd nmos W=w_Mn3 L=l_Mn3
Mref1 p2 p2 vdd vdd pmos W=w_Mref1 L=l_Mref1
Mmirror1 p3 p2 vdd vdd pmos W=w_Mmirror1 L=l_Mmirror1
Msupport1 p3 b2 gnd gnd nmos W=w_Msupport1 L=l_Msupport1
Mn4 n_series_4 p3 gnd gnd nmos W=w_Mn4 L=l_Mn4
Mn5 out b3 n_series_4 gnd nmos W=w_Mn5 L=l_Mn5
Mp1 out b4 vdd vdd pmos W=w_Mp1 L=l_Mp1
Mffmirror1 out n_diff_2 vdd vdd pmos W=w_Mffmirror1 L=l_Mffmirror1
Mdfc1 n_dfc_5 p2 vdd vdd pmos W=w_Mdfc1 L=l_Mdfc1
Mn6 n_dfc_5 b5 gnd gnd nmos W=w_Mn6 L=l_Mn6

Cc1 out p1 c=c_Cc1
Cdfc1 n_dfc_5 p2 c=c_Cdfc1
CL out gnd c=c_CL
.ENDS CKTCASE
