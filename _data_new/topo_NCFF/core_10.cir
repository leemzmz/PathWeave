*auto-generated subcircuit netlist (from TopoGen)
.SUBCKT CKTCASE ipos ineg out b0 b1 b2 b3 b4 b5 b6 b7 b8 vdd gnd
*.PININFO ipos:I ineg:I out:O b0:B b1:B b2:B b3:B b4:B b5:B b6:B b7:B b8:B vdd:B gnd:B

Mp1 n_diff_2 ipos n_tail_1 vdd pmos W=w_Mp1 L=l_Mp1
Mp2 n_diff_3 ineg n_tail_1 vdd pmos W=w_Mp2 L=l_Mp2
Mtail1 n_tail_1 b0 vdd vdd pmos W=w_Mtail1 L=l_Mtail1
MfoldSource1 n_diff_2 b1 gnd gnd nmos W=w_MfoldSource1 L=l_MfoldSource1
MfoldSource2 n_diff_3 b1 gnd gnd nmos W=w_MfoldSource2 L=l_MfoldSource2
Mfold1 p1 b2 n_diff_2 gnd nmos W=w_Mfold1 L=l_Mfold1
Mfold2 n_fold_4 b2 n_diff_3 gnd nmos W=w_Mfold2 L=l_Mfold2
MloadRef1 n_fold_4 n_fold_4 vdd vdd pmos W=w_MloadRef1 L=l_MloadRef1
MloadMirror1 p1 n_fold_4 vdd vdd pmos W=w_MloadMirror1 L=l_MloadMirror1
Mp3 n_series_5 p1 vdd vdd pmos W=w_Mp3 L=l_Mp3
Mp4 n_series_6 b3 n_series_5 vdd pmos W=w_Mp4 L=l_Mp4
Mp5 p2 b4 n_series_6 vdd pmos W=w_Mp5 L=l_Mp5
Mref1 p2 p2 gnd gnd nmos W=w_Mref1 L=l_Mref1
Mmirror1 p3 p2 gnd gnd nmos W=w_Mmirror1 L=l_Mmirror1
Msupport1 p3 b5 n_rail_7 vdd pmos W=w_Msupport1 L=l_Msupport1
Msupport2 n_rail_7 b6 n_rail_8 vdd pmos W=w_Msupport2 L=l_Msupport2
Msupport3 n_rail_8 b7 vdd vdd pmos W=w_Msupport3 L=l_Msupport3
Mp6 p4 p3 vdd vdd pmos W=w_Mp6 L=l_Mp6
Mref2 p4 p4 gnd gnd nmos W=w_Mref2 L=l_Mref2
Mmirror2 out p4 gnd gnd nmos W=w_Mmirror2 L=l_Mmirror2
Msupport4 out b8 vdd vdd pmos W=w_Msupport4 L=l_Msupport4
Mff1 p3 ipos gnd gnd nmos W=w_Mff1 L=l_Mff1
Mff2 out ipos vdd vdd pmos W=w_Mff2 L=l_Mff2

CL out gnd c=c_CL
.ENDS CKTCASE
