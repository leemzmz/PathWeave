*auto-generated subcircuit netlist (from TopoGen)
.SUBCKT CKTCASE ipos ineg out b0 b1 b2 b3 b4 b5 b6 b7 b8 vdd gnd
*.PININFO ipos:I ineg:I out:O b0:B b1:B b2:B b3:B b4:B b5:B b6:B b7:B b8:B vdd:B gnd:B

Mp1 p1 ipos n_tail_1 vdd pmos W=w_Mp1 L=l_Mp1
Mp2 n_diff_2 ineg n_tail_1 vdd pmos W=w_Mp2 L=l_Mp2
Mtail1 n_tail_1 b0 vdd vdd pmos W=w_Mtail1 L=l_Mtail1
MloadRef1 n_diff_2 n_diff_2 gnd gnd nmos W=w_MloadRef1 L=l_MloadRef1
MloadMirror1 p1 n_diff_2 gnd gnd nmos W=w_MloadMirror1 L=l_MloadMirror1
Mp3 n_series_3 p1 vdd vdd pmos W=w_Mp3 L=l_Mp3
Mp4 n_series_4 b1 n_series_3 vdd pmos W=w_Mp4 L=l_Mp4
Mp5 p2 b2 n_series_4 vdd pmos W=w_Mp5 L=l_Mp5
Mref1 p2 p2 gnd gnd nmos W=w_Mref1 L=l_Mref1
Mmirror1 p3 p2 gnd gnd nmos W=w_Mmirror1 L=l_Mmirror1
Msupport1 p3 b3 n_rail_5 vdd pmos W=w_Msupport1 L=l_Msupport1
Msupport2 n_rail_5 b4 n_rail_6 vdd pmos W=w_Msupport2 L=l_Msupport2
Msupport3 n_rail_6 b5 vdd vdd pmos W=w_Msupport3 L=l_Msupport3
Mn1 n_series_7 p3 gnd gnd nmos W=w_Mn1 L=l_Mn1
Mn2 p4 b6 n_series_7 gnd nmos W=w_Mn2 L=l_Mn2
Mref2 p4 p4 vdd vdd pmos W=w_Mref2 L=l_Mref2
Mmirror2 out p4 vdd vdd pmos W=w_Mmirror2 L=l_Mmirror2
Msupport4 out b7 n_rail_8 gnd nmos W=w_Msupport4 L=l_Msupport4
Msupport5 n_rail_8 b8 gnd gnd nmos W=w_Msupport5 L=l_Msupport5
Mff1 p3 ipos vdd vdd pmos W=w_Mff1 L=l_Mff1
Mff2 out ipos vdd vdd pmos W=w_Mff2 L=l_Mff2

CL out gnd c=c_CL
.ENDS CKTCASE
