*auto-generated subcircuit netlist (from TopoGen)
.SUBCKT CKTCASE ipos ineg out b0 b1 b2 b3 vdd gnd
*.PININFO ipos:I ineg:I out:O b0:B b1:B b2:B b3:B vdd:B gnd:B

Mp1 p1 ipos n_tail_1 vdd pmos W=w_Mp1 L=l_Mp1
Mp2 n_diff_2 ineg n_tail_1 vdd pmos W=w_Mp2 L=l_Mp2
Mtail1 n_tail_1 b0 vdd vdd pmos W=w_Mtail1 L=l_Mtail1
MloadRef1 n_diff_2 n_diff_2 gnd gnd nmos W=w_MloadRef1 L=l_MloadRef1
MloadMirror1 p1 n_diff_2 gnd gnd nmos W=w_MloadMirror1 L=l_MloadMirror1
Mp3 n_series_3 p1 vdd vdd pmos W=w_Mp3 L=l_Mp3
Mp4 n_series_4 b1 n_series_3 vdd pmos W=w_Mp4 L=l_Mp4
Mp5 out b2 n_series_4 vdd pmos W=w_Mp5 L=l_Mp5
Mn1 out b3 gnd gnd nmos W=w_Mn1 L=l_Mn1

Rc1 out n_nr_5 r=r_Rc1
Cc1 n_nr_5 p1 c=c_Cc1
CL out gnd c=c_CL
.ENDS CKTCASE
