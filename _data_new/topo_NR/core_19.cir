*auto-generated subcircuit netlist (from TopoGen)
.SUBCKT CKTCASE ipos ineg out b0 b1 b2 b3 b4 b5 vdd gnd
*.PININFO ipos:I ineg:I out:O b0:B b1:B b2:B b3:B b4:B b5:B vdd:B gnd:B

Mp1 n_diff_2 ipos n_tail_1 vdd pmos W=w_Mp1 L=l_Mp1
Mp2 n_diff_3 ineg n_tail_1 vdd pmos W=w_Mp2 L=l_Mp2
Mtail1 n_tail_1 b0 n_rail_4 vdd pmos W=w_Mtail1 L=l_Mtail1
Mtail2 n_rail_4 b1 vdd vdd pmos W=w_Mtail2 L=l_Mtail2
MfoldSource1 n_diff_2 b2 gnd gnd nmos W=w_MfoldSource1 L=l_MfoldSource1
MfoldSource2 n_diff_3 b2 gnd gnd nmos W=w_MfoldSource2 L=l_MfoldSource2
Mfold1 p1 b3 n_diff_2 gnd nmos W=w_Mfold1 L=l_Mfold1
Mfold2 n_fold_5 b3 n_diff_3 gnd nmos W=w_Mfold2 L=l_Mfold2
MloadRef1 n_fold_5 n_fold_5 vdd vdd pmos W=w_MloadRef1 L=l_MloadRef1
MloadMirror1 p1 n_fold_5 vdd vdd pmos W=w_MloadMirror1 L=l_MloadMirror1
Mn1 n_series_6 p1 gnd gnd nmos W=w_Mn1 L=l_Mn1
Mn2 out b4 n_series_6 gnd nmos W=w_Mn2 L=l_Mn2
Mp3 out b5 vdd vdd pmos W=w_Mp3 L=l_Mp3

Rc1 out n_nr_7 r=r_Rc1
Cc1 n_nr_7 p1 c=c_Cc1
CL out gnd c=c_CL
.ENDS CKTCASE
