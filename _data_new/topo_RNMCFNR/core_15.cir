*auto-generated subcircuit netlist (from TopoGen)
.SUBCKT CKTCASE ipos ineg out b0 b1 b2 b3 b4 vdd gnd
*.PININFO ipos:I ineg:I out:O b0:B b1:B b2:B b3:B b4:B vdd:B gnd:B

Mn1 p1 ipos n_tail_1 gnd nmos W=w_Mn1 L=l_Mn1
Mn2 n_diff_2 ineg n_tail_1 gnd nmos W=w_Mn2 L=l_Mn2
Mtail1 n_tail_1 b0 gnd gnd nmos W=w_Mtail1 L=l_Mtail1
MloadCas1 n_diff_2 b1 n_load_3 vdd pmos W=w_MloadCas1 L=l_MloadCas1
MloadCas2 p1 b1 n_load_4 vdd pmos W=w_MloadCas2 L=l_MloadCas2
MloadRef1 n_load_3 n_load_3 vdd vdd pmos W=w_MloadRef1 L=l_MloadRef1
MloadMirror1 n_load_4 n_load_3 vdd vdd pmos W=w_MloadMirror1 L=l_MloadMirror1
Mn3 n_series_5 p1 gnd gnd nmos W=w_Mn3 L=l_Mn3
Mn4 p2 b2 n_series_5 gnd nmos W=w_Mn4 L=l_Mn4
Mp1 p2 b3 vdd vdd pmos W=w_Mp1 L=l_Mp1
Mn5 p3 p2 gnd gnd nmos W=w_Mn5 L=l_Mn5
Mref1 p3 p3 vdd vdd pmos W=w_Mref1 L=l_Mref1
Mmirror1 out p3 vdd vdd pmos W=w_Mmirror1 L=l_Mmirror1
Msupport1 out b4 gnd gnd nmos W=w_Msupport1 L=l_Msupport1
Mff1 out p1 vdd vdd pmos W=w_Mff1 L=l_Mff1

Rc1 p2 n_nr_6 r=r_Rc1
Cc1 n_nr_6 p1 c=c_Cc1
Rc2 out n_nr_7 r=r_Rc2
Cc2 n_nr_7 p1 c=c_Cc2
CL out gnd c=c_CL
.ENDS CKTCASE
