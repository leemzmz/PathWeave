*auto-generated subcircuit netlist (from TopoGen)
.SUBCKT CKTCASE vref vfb vout b0 b1 b2 b3 b4 b5 b6 b7 b8 vdd gnd
*.PININFO vref:I vfb:I vout:O b0:B b1:B b2:B b3:B b4:B b5:B b6:B b7:B b8:B vdd:B gnd:B

Mn1 n_diff_2 vref n_tail_1 gnd nmos W=w_Mn1 L=l_Mn1
Mn2 n_diff_3 vfb n_tail_1 gnd nmos W=w_Mn2 L=l_Mn2
Mtail1 n_tail_1 b0 n_rail_4 gnd nmos W=w_Mtail1 L=l_Mtail1
Mtail2 n_rail_4 b1 gnd gnd nmos W=w_Mtail2 L=l_Mtail2
MfoldSource1 n_diff_2 b2 vdd vdd pmos W=w_MfoldSource1 L=l_MfoldSource1
MfoldSource2 n_diff_3 b2 vdd vdd pmos W=w_MfoldSource2 L=l_MfoldSource2
Mfold1 p1 b3 n_diff_2 vdd pmos W=w_Mfold1 L=l_Mfold1
Mfold2 n_fold_5 b3 n_diff_3 vdd pmos W=w_Mfold2 L=l_Mfold2
MloadCas1 n_fold_5 b4 n_load_6 gnd nmos W=w_MloadCas1 L=l_MloadCas1
MloadCas2 p1 b4 n_load_7 gnd nmos W=w_MloadCas2 L=l_MloadCas2
MloadRef1 n_load_6 n_load_6 gnd gnd nmos W=w_MloadRef1 L=l_MloadRef1
MloadMirror1 n_load_7 n_load_6 gnd gnd nmos W=w_MloadMirror1 L=l_MloadMirror1
Mn3 p2 p1 gnd gnd nmos W=w_Mn3 L=l_Mn3
Mp1 p2 b5 vdd vdd pmos W=w_Mp1 L=l_Mp1
Mp2 n_series_8 p2 vdd vdd pmos W=w_Mp2 L=l_Mp2
Mp3 p3 b6 n_series_8 vdd pmos W=w_Mp3 L=l_Mp3
Mref1 p3 p3 gnd gnd nmos W=w_Mref1 L=l_Mref1
Mmirror1 p4 p3 gnd gnd nmos W=w_Mmirror1 L=l_Mmirror1
Msupport1 p4 b7 n_rail_9 vdd pmos W=w_Msupport1 L=l_Msupport1
Msupport2 n_rail_9 b8 vdd vdd pmos W=w_Msupport2 L=l_Msupport2
Mpass1 vout p4 vdd vdd pmos W=w_Mpass1 L=l_Mpass1
Mff1 p3 p1 vdd vdd pmos W=w_Mff1 L=l_Mff1
Mgf1 vout vout vfb gnd nmos W=w_Mgf1 L=l_Mgf1
Mgf2 vfb vfb gnd gnd nmos W=w_Mgf2 L=l_Mgf2

Rc1 p2 n_nr_10 r=r_Rc1
Cc1 n_nr_10 p1 c=c_Cc1
Cc2 vout p1 c=c_Cc2
CL vout gnd c=c_CL
.ENDS CKTCASE
