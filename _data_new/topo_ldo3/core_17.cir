*auto-generated subcircuit netlist (from TopoGen)
.SUBCKT CKTCASE vref vfb vout b0 b1 b2 b3 b4 b5 b6 b7 b8 b9 b10 b11 vdd gnd
*.PININFO vref:I vfb:I vout:O b0:B b1:B b2:B b3:B b4:B b5:B b6:B b7:B b8:B b9:B b10:B b11:B vdd:B gnd:B

Mn1 n_diff_2 vref n_tail_1 gnd nmos W=w_Mn1 L=l_Mn1
Mn2 n_diff_3 vfb n_tail_1 gnd nmos W=w_Mn2 L=l_Mn2
Mtail1 n_tail_1 b0 gnd gnd nmos W=w_Mtail1 L=l_Mtail1
MfoldSource1 n_diff_2 b1 vdd vdd pmos W=w_MfoldSource1 L=l_MfoldSource1
MfoldSource2 n_diff_3 b1 vdd vdd pmos W=w_MfoldSource2 L=l_MfoldSource2
Mfold1 p1 b2 n_diff_2 vdd pmos W=w_Mfold1 L=l_Mfold1
Mfold2 n_fold_4 b2 n_diff_3 vdd pmos W=w_Mfold2 L=l_Mfold2
MloadCas1 n_fold_4 b3 n_load_5 gnd nmos W=w_MloadCas1 L=l_MloadCas1
MloadCas2 p1 b3 n_load_6 gnd nmos W=w_MloadCas2 L=l_MloadCas2
MloadRef1 n_load_5 n_load_5 gnd gnd nmos W=w_MloadRef1 L=l_MloadRef1
MloadMirror1 n_load_6 n_load_5 gnd gnd nmos W=w_MloadMirror1 L=l_MloadMirror1
Mp1 n_series_7 p1 vdd vdd pmos W=w_Mp1 L=l_Mp1
Mp2 n_series_8 b4 n_series_7 vdd pmos W=w_Mp2 L=l_Mp2
Mp3 p2 b5 n_series_8 vdd pmos W=w_Mp3 L=l_Mp3
Mn3 p2 b6 gnd gnd nmos W=w_Mn3 L=l_Mn3
Mp4 n_series_9 p2 vdd vdd pmos W=w_Mp4 L=l_Mp4
Mp5 n_series_10 b7 n_series_9 vdd pmos W=w_Mp5 L=l_Mp5
Mp6 p3 b8 n_series_10 vdd pmos W=w_Mp6 L=l_Mp6
Mref1 p3 p3 gnd gnd nmos W=w_Mref1 L=l_Mref1
Mmirror1 p4 p3 gnd gnd nmos W=w_Mmirror1 L=l_Mmirror1
Msupport1 p4 b9 n_rail_11 vdd pmos W=w_Msupport1 L=l_Msupport1
Msupport2 n_rail_11 b10 n_rail_12 vdd pmos W=w_Msupport2 L=l_Msupport2
Msupport3 n_rail_12 b11 vdd vdd pmos W=w_Msupport3 L=l_Msupport3
Mpass1 vout p4 vdd vdd pmos W=w_Mpass1 L=l_Mpass1
Mff1 p3 p1 vdd vdd pmos W=w_Mff1 L=l_Mff1

Rc1 p2 n_nr_13 r=r_Rc1
Cc1 n_nr_13 p1 c=c_Cc1
Cc2 vout p1 c=c_Cc2
Rgf1 vout vfb r=r_Rgf1
Rgf2 vfb gnd r=r_Rgf2
CL vout gnd c=c_CL
.ENDS CKTCASE
