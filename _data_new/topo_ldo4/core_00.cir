*auto-generated subcircuit netlist (from TopoGen)
.SUBCKT CKTCASE vref vfb vout b0 b1 b2 vdd gnd
*.PININFO vref:I vfb:I vout:O b0:B b1:B b2:B vdd:B gnd:B

Mn1 p1 vref n_tail_1 gnd nmos W=w_Mn1 L=l_Mn1
Mn2 n_diff_2 vfb n_tail_1 gnd nmos W=w_Mn2 L=l_Mn2
Mtail1 n_tail_1 b0 n_rail_3 gnd nmos W=w_Mtail1 L=l_Mtail1
Mtail2 n_rail_3 b1 gnd gnd nmos W=w_Mtail2 L=l_Mtail2
MloadRef1 n_diff_2 n_diff_2 vdd vdd pmos W=w_MloadRef1 L=l_MloadRef1
MloadMirror1 p1 n_diff_2 vdd vdd pmos W=w_MloadMirror1 L=l_MloadMirror1
Mp1 p2 p1 vdd vdd pmos W=w_Mp1 L=l_Mp1
Mn3 p2 b2 gnd gnd nmos W=w_Mn3 L=l_Mn3
Mpass1 vout p2 vdd vdd pmos W=w_Mpass1 L=l_Mpass1
Mgf1 vout vout vfb gnd nmos W=w_Mgf1 L=l_Mgf1
Mgf2 vfb vfb gnd gnd nmos W=w_Mgf2 L=l_Mgf2

Rc1 p2 n_nr_4 r=r_Rc1
Cc1 n_nr_4 p1 c=c_Cc1
CL vout gnd c=c_CL
.ENDS CKTCASE
