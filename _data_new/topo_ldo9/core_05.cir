*auto-generated subcircuit netlist (from TopoGen)
.SUBCKT CKTCASE vref vfb vout b0 b1 b2 b3 b4 b5 vdd gnd
*.PININFO vref:I vfb:I vout:O b0:B b1:B b2:B b3:B b4:B b5:B vdd:B gnd:B

Mp1 n_diff_2 vref n_tail_1 vdd pmos W=w_Mp1 L=l_Mp1
Mp2 n_diff_3 vfb n_tail_1 vdd pmos W=w_Mp2 L=l_Mp2
Mtail1 n_tail_1 b0 vdd vdd pmos W=w_Mtail1 L=l_Mtail1
MfoldSource1 n_diff_2 b1 gnd gnd nmos W=w_MfoldSource1 L=l_MfoldSource1
MfoldSource2 n_diff_3 b1 gnd gnd nmos W=w_MfoldSource2 L=l_MfoldSource2
Mfold1 p1 b2 n_diff_2 gnd nmos W=w_Mfold1 L=l_Mfold1
Mfold2 n_fold_4 b2 n_diff_3 gnd nmos W=w_Mfold2 L=l_Mfold2
MloadRef1 n_fold_4 n_fold_4 vdd vdd pmos W=w_MloadRef1 L=l_MloadRef1
MloadMirror1 p1 n_fold_4 vdd vdd pmos W=w_MloadMirror1 L=l_MloadMirror1
Mp3 n_series_5 p1 vdd vdd pmos W=w_Mp3 L=l_Mp3
Mp4 p2 b3 n_series_5 vdd pmos W=w_Mp4 L=l_Mp4
Mref1 p2 p2 gnd gnd nmos W=w_Mref1 L=l_Mref1
Mmirror1 p3 p2 gnd gnd nmos W=w_Mmirror1 L=l_Mmirror1
Msupport1 p3 b4 n_rail_6 vdd pmos W=w_Msupport1 L=l_Msupport1
Msupport2 n_rail_6 b5 vdd vdd pmos W=w_Msupport2 L=l_Msupport2
Mpass1 vout p3 vdd vdd pmos W=w_Mpass1 L=l_Mpass1
Mffmirror1 p3 n_fold_4 vdd vdd pmos W=w_Mffmirror1 L=l_Mffmirror1
Mgf1 vout vout vfb gnd nmos W=w_Mgf1 L=l_Mgf1
Mgf2 vfb vfb gnd gnd nmos W=w_Mgf2 L=l_Mgf2

Rc1 p3 n_nr_7 r=r_Rc1
Cc1 n_nr_7 p1 c=c_Cc1
Riac1 p2 n_iac_8 r=r_Riac1
Ciac1 n_iac_8 gnd c=c_Ciac1
CL vout gnd c=c_CL
.ENDS CKTCASE
