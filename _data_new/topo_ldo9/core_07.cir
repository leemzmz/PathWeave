*auto-generated subcircuit netlist (from TopoGen)
.SUBCKT CKTCASE vref vfb vout b0 b1 b2 b3 b4 b5 vdd gnd
*.PININFO vref:I vfb:I vout:O b0:B b1:B b2:B b3:B b4:B b5:B vdd:B gnd:B

Mn1 p1 vref n_tail_1 gnd nmos W=w_Mn1 L=l_Mn1
Mn2 n_diff_2 vfb n_tail_1 gnd nmos W=w_Mn2 L=l_Mn2
Mtail1 n_tail_1 b0 gnd gnd nmos W=w_Mtail1 L=l_Mtail1
MloadRef1 n_diff_2 n_diff_2 vdd vdd pmos W=w_MloadRef1 L=l_MloadRef1
MloadMirror1 p1 n_diff_2 vdd vdd pmos W=w_MloadMirror1 L=l_MloadMirror1
Mn3 n_series_3 p1 gnd gnd nmos W=w_Mn3 L=l_Mn3
Mn4 n_series_4 b1 n_series_3 gnd nmos W=w_Mn4 L=l_Mn4
Mn5 p2 b2 n_series_4 gnd nmos W=w_Mn5 L=l_Mn5
Mref1 p2 p2 vdd vdd pmos W=w_Mref1 L=l_Mref1
Mmirror1 p3 p2 vdd vdd pmos W=w_Mmirror1 L=l_Mmirror1
Msupport1 p3 b3 n_rail_5 gnd nmos W=w_Msupport1 L=l_Msupport1
Msupport2 n_rail_5 b4 n_rail_6 gnd nmos W=w_Msupport2 L=l_Msupport2
Msupport3 n_rail_6 b5 gnd gnd nmos W=w_Msupport3 L=l_Msupport3
Mpass1 vout p3 vdd vdd pmos W=w_Mpass1 L=l_Mpass1
Mffmirror1 p3 n_diff_2 vdd vdd pmos W=w_Mffmirror1 L=l_Mffmirror1
Mgf1 vout vout vfb gnd nmos W=w_Mgf1 L=l_Mgf1
Mgf2 vfb vfb gnd gnd nmos W=w_Mgf2 L=l_Mgf2

Rc1 p3 n_nr_7 r=r_Rc1
Cc1 n_nr_7 p1 c=c_Cc1
Riac1 p2 n_iac_8 r=r_Riac1
Ciac1 n_iac_8 gnd c=c_Ciac1
CL vout gnd c=c_CL
.ENDS CKTCASE
