*auto-generated subcircuit netlist (from TopoGen)
.SUBCKT CKTCASE ipos ineg out b0 b1 b2 b3 b4 b5 b6 b7 vdd gnd
*.PININFO ipos:I ineg:I out:O b0:B b1:B b2:B b3:B b4:B b5:B b6:B b7:B vdd:B gnd:B

Mn1 p1 ipos n_tail_1 gnd nmos W=w_Mn1 L=l_Mn1
Mn2 n_diff_2 ineg n_tail_1 gnd nmos W=w_Mn2 L=l_Mn2
Mtail1 n_tail_1 b0 gnd gnd nmos W=w_Mtail1 L=l_Mtail1
MloadCas1 n_diff_2 b1 n_load_3 vdd pmos W=w_MloadCas1 L=l_MloadCas1
MloadCas2 p1 b1 n_load_4 vdd pmos W=w_MloadCas2 L=l_MloadCas2
MloadRef1 n_load_3 n_load_3 vdd vdd pmos W=w_MloadRef1 L=l_MloadRef1
MloadMirror1 n_load_4 n_load_3 vdd vdd pmos W=w_MloadMirror1 L=l_MloadMirror1
Mn3 n_series_5 p1 gnd gnd nmos W=w_Mn3 L=l_Mn3
Mn4 p2 b2 n_series_5 gnd nmos W=w_Mn4 L=l_Mn4
Mref1 p2 p2 vdd vdd pmos W=w_Mref1 L=l_Mref1
Mmirror1 p3 p2 vdd vdd pmos W=w_Mmirror1 L=l_Mmirror1
Msupport1 p3 b3 n_rail_6 gnd nmos W=w_Msupport1 L=l_Msupport1
Msupport2 n_rail_6 b4 gnd gnd nmos W=w_Msupport2 L=l_Msupport2
Mn5 out p3 gnd gnd nmos W=w_Mn5 L=l_Mn5
Mp1 out b5 vdd vdd pmos W=w_Mp1 L=l_Mp1
Macb1 n_acb_7 p2 vdd vdd pmos W=w_Macb1 L=l_Macb1
Mn6 n_acb_7 b6 gnd gnd nmos W=w_Mn6 L=l_Mn6
Mvb1 n_vb_8 p3 vdd vdd pmos W=w_Mvb1 L=l_Mvb1
Mn7 n_vb_8 b7 gnd gnd nmos W=w_Mn7 L=l_Mn7
Mff1 p3 ipos vdd vdd pmos W=w_Mff1 L=l_Mff1

Cacb1 n_acb_7 p3 c=c_Cacb1
Cvb1 n_vb_8 p1 c=c_Cvb1
CL out gnd c=c_CL
.ENDS CKTCASE
