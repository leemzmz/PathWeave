*auto-generated subcircuit netlist (from TopoGen)
.SUBCKT CKTCASE ipos ineg out b0 b1 b2 b3 b4 b5 b6 b7 b8 b9 vdd gnd
*.PININFO ipos:I ineg:I out:O b0:B b1:B b2:B b3:B b4:B b5:B b6:B b7:B b8:B b9:B vdd:B gnd:B

Mn1 p1 ipos n_tail_1 gnd nmos W=w_Mn1 L=l_Mn1
Mn2 n_diff_2 ineg n_tail_1 gnd nmos W=w_Mn2 L=l_Mn2
Mtail1 n_tail_1 b0 gnd gnd nmos W=w_Mtail1 L=l_Mtail1
MloadCas1 n_diff_2 b1 n_load_3 vdd pmos W=w_MloadCas1 L=l_MloadCas1
MloadCas2 p1 b1 n_load_4 vdd pmos W=w_MloadCas2 L=l_MloadCas2
MloadRef1 n_load_3 n_load_3 vdd vdd pmos W=w_MloadRef1 L=l_MloadRef1
MloadMirror1 n_load_4 n_load_3 vdd vdd pmos W=w_MloadMirror1 L=l_MloadMirror1
Mn3 n_series_5 p1 gnd gnd nmos W=w_Mn3 L=l_Mn3
Mn4 p2 b2 n_series_5 gnd nmos W=w_Mn4 L=l_Mn4
Mp1 p2 b3 vdd vdd pmos W=w_Mp1 L=l_Mp1
Mn5 n_series_6 p2 gnd gnd nmos W=w_Mn5 L=l_Mn5
Mn6 n_series_7 b4 n_series_6 gnd nmos W=w_Mn6 L=l_Mn6
Mn7 p3 b5 n_series_7 gnd nmos W=w_Mn7 L=l_Mn7
Mref1 p3 p3 vdd vdd pmos W=w_Mref1 L=l_Mref1
Mmirror1 out p3 vdd vdd pmos W=w_Mmirror1 L=l_Mmirror1
Msupport1 out b6 n_rail_8 gnd nmos W=w_Msupport1 L=l_Msupport1
Msupport2 n_rail_8 b7 n_rail_9 gnd nmos W=w_Msupport2 L=l_Msupport2
Msupport3 n_rail_9 b8 gnd gnd nmos W=w_Msupport3 L=l_Msupport3
Macb1 n_acb_12 p1 vdd vdd pmos W=w_Macb1 L=l_Macb1
Mn8 n_acb_12 b9 gnd gnd nmos W=w_Mn8 L=l_Mn8
Mff1 p2 ipos gnd gnd nmos W=w_Mff1 L=l_Mff1

Riac1 p2 n_iac_10 r=r_Riac1
Ciac1 n_iac_10 gnd c=c_Ciac1
Rc1 out n_nr_11 r=r_Rc1
Cc1 n_nr_11 p1 c=c_Cc1
Cacb1 n_acb_12 p3 c=c_Cacb1
CL out gnd c=c_CL
.ENDS CKTCASE
