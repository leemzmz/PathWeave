*auto-generated subcircuit netlist (from TopoGen)
.SUBCKT CKTCASE ipos ineg out b0 b1 b2 b3 b4 b5 b6 b7 b8 b9 b10 vdd gnd
*.PININFO ipos:I ineg:I out:O b0:B b1:B b2:B b3:B b4:B b5:B b6:B b7:B b8:B b9:B b10:B vdd:B gnd:B

Mn1 n_diff_2 ipos n_tail_1 gnd nmos W=w_Mn1 L=l_Mn1
Mn2 n_diff_3 ineg n_tail_1 gnd nmos W=w_Mn2 L=l_Mn2
Mtail1 n_tail_1 b0 n_rail_4 gnd nmos W=w_Mtail1 L=l_Mtail1
Mtail2 n_rail_4 b1 gnd gnd nmos W=w_Mtail2 L=l_Mtail2
MfoldSource1 n_diff_2 b2 vdd vdd pmos W=w_MfoldSource1 L=l_MfoldSource1
MfoldSource2 n_diff_3 b2 vdd vdd pmos W=w_MfoldSource2 L=l_MfoldSource2
Mfold1 p1 b3 n_diff_2 vdd pmos W=w_Mfold1 L=l_Mfold1
Mfold2 n_fold_5 b3 n_diff_3 vdd pmos W=w_Mfold2 L=l_Mfold2
MloadCas1 n_fold_5 b4 n_load_6 gnd nmos W=w_MloadCas1 L=l_MloadCas1
MloadCas2 p1 b4 n_load_7 gnd nmos W=w_MloadCas2 L=l_MloadCas2
MloadRef1 n_load_6 n_load_6 gnd gnd nmos W=w_MloadRef1 L=l_MloadRef1
MloadMirror1 n_load_7 n_load_6 gnd gnd nmos W=w_MloadMirror1 L=l_MloadMirror1
Mn3 n_series_8 p1 gnd gnd nmos W=w_Mn3 L=l_Mn3
Mn4 p2 b5 n_series_8 gnd nmos W=w_Mn4 L=l_Mn4
Mp1 p2 b6 vdd vdd pmos W=w_Mp1 L=l_Mp1
Mn5 n_series_9 p2 gnd gnd nmos W=w_Mn5 L=l_Mn5
Mn6 p3 b7 n_series_9 gnd nmos W=w_Mn6 L=l_Mn6
Mref1 p3 p3 vdd vdd pmos W=w_Mref1 L=l_Mref1
Mmirror1 out p3 vdd vdd pmos W=w_Mmirror1 L=l_Mmirror1
Msupport1 out b8 n_rail_10 gnd nmos W=w_Msupport1 L=l_Msupport1
Msupport2 n_rail_10 b9 gnd gnd nmos W=w_Msupport2 L=l_Msupport2
Macb1 n_acb_13 p1 vdd vdd pmos W=w_Macb1 L=l_Macb1
Mn7 n_acb_13 b10 gnd gnd nmos W=w_Mn7 L=l_Mn7
Mff1 p2 ipos vdd vdd pmos W=w_Mff1 L=l_Mff1

Riac1 p2 n_iac_11 r=r_Riac1
Ciac1 n_iac_11 gnd c=c_Ciac1
Rc1 out n_nr_12 r=r_Rc1
Cc1 n_nr_12 p1 c=c_Cc1
Cacb1 n_acb_13 p3 c=c_Cacb1
CL out gnd c=c_CL
.ENDS CKTCASE
