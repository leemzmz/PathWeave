*auto-generated subcircuit netlist (from TopoGen)
.SUBCKT CKTCASE ipos ineg out b0 b1 b2 b3 b4 b5 b6 b7 b8 b9 b10 vdd gnd
*.PININFO ipos:I ineg:I out:O b0:B b1:B b2:B b3:B b4:B b5:B b6:B b7:B b8:B b9:B b10:B vdd:B gnd:B

Mp1 p1 ipos n_tail_1 vdd pmos W=w_Mp1 L=l_Mp1
Mp2 n_diff_2 ineg n_tail_1 vdd pmos W=w_Mp2 L=l_Mp2
Mtail1 n_tail_1 b0 n_rail_3 vdd pmos W=w_Mtail1 L=l_Mtail1
Mtail2 n_rail_3 b1 vdd vdd pmos W=w_Mtail2 L=l_Mtail2
MloadRef1 n_diff_2 n_diff_2 gnd gnd nmos W=w_MloadRef1 L=l_MloadRef1
MloadMirror1 p1 n_diff_2 gnd gnd nmos W=w_MloadMirror1 L=l_MloadMirror1
Mp3 n_series_4 p1 vdd vdd pmos W=w_Mp3 L=l_Mp3
Mp4 n_series_5 b2 n_series_4 vdd pmos W=w_Mp4 L=l_Mp4
Mp5 p2 b3 n_series_5 vdd pmos W=w_Mp5 L=l_Mp5
Mn1 p2 b4 gnd gnd nmos W=w_Mn1 L=l_Mn1
Mp6 n_series_6 p2 vdd vdd pmos W=w_Mp6 L=l_Mp6
Mp7 n_series_7 b5 n_series_6 vdd pmos W=w_Mp7 L=l_Mp7
Mp8 p3 b6 n_series_7 vdd pmos W=w_Mp8 L=l_Mp8
Mref1 p3 p3 gnd gnd nmos W=w_Mref1 L=l_Mref1
Mmirror1 out p3 gnd gnd nmos W=w_Mmirror1 L=l_Mmirror1
Msupport1 out b7 n_rail_8 vdd pmos W=w_Msupport1 L=l_Msupport1
Msupport2 n_rail_8 b8 n_rail_9 vdd pmos W=w_Msupport2 L=l_Msupport2
Msupport3 n_rail_9 b9 vdd vdd pmos W=w_Msupport3 L=l_Msupport3
Macb1 n_acb_12 p1 gnd gnd nmos W=w_Macb1 L=l_Macb1
Mp9 n_acb_12 b10 vdd vdd pmos W=w_Mp9 L=l_Mp9
Mff1 p2 ipos gnd gnd nmos W=w_Mff1 L=l_Mff1

Riac1 p2 n_iac_10 r=r_Riac1
Ciac1 n_iac_10 gnd c=c_Ciac1
Rc1 out n_nr_11 r=r_Rc1
Cc1 n_nr_11 p1 c=c_Cc1
Cacb1 n_acb_12 p3 c=c_Cacb1
CL out gnd c=c_CL
.ENDS CKTCASE
